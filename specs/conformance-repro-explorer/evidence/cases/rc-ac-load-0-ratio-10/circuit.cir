KiCadAI frozen conformance rc-ac-load-0-ratio-10
V1 vin 0 DC 5 AC 1
R1 vin out 10000
C1 out 0 9.9999999999999995e-08
.options reltol=1e-9 abstol=1e-12 vntol=1e-10
.control
set noaskquit
set numdgt=17
ac lin 2 1591.5494309189532 15915.494309189533
let observed_real=real(v(out)[0])
let observed_imag=imag(v(out)[0])
print observed_real
print observed_imag
quit
.endc
.end
