KiCadAI frozen conformance rc-ac-load-10000-ratio-0.1
V1 vin 0 DC 5 AC 1
R1 vin out 10000
C1 out 0 9.9999999999999995e-08
RL out 0 10000
.options reltol=1e-9 abstol=1e-12 vntol=1e-10
.control
set noaskquit
set numdgt=17
ac lin 2 31.830988618379067 318.3098861837907
let observed_real=real(v(out)[0])
let observed_imag=imag(v(out)[0])
print observed_real
print observed_imag
quit
.endc
.end
