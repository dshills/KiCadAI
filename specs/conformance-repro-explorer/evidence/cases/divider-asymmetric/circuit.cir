KiCadAI frozen conformance divider-asymmetric
V1 vin 0 DC 3.2999999999999998 AC 1
R1 vin out 4700
R2 out 0 2200
.options reltol=1e-9 abstol=1e-12 vntol=1e-10
.control
set noaskquit
set numdgt=17
op
let observed_real=v(out)
let observed_imag=0
print observed_real
print observed_imag
quit
.endc
.end
